// Verilog-AMS netlist generated by the AMS netlister, version  IC6.1.6-64b.500.11 .
// Cadence Design Systems, Inc.

`include "disciplines.vams"

(* cds_ams_schematic *)
module uwb_pll_topo_tb (  );

uwb_pll_topo (*
integer library_binding = "uwb_system";
 *)
I61 ( .XTALN(
XTALN ), .TRIMP( gnd_vco ), .I_SRC_10U( I_SINK_10u ), .CLK_FB( CLK_FB ),
.GND_VCO( gnd_vco ), .VDD_VCO( vdd_vco ), .VDD_1( vdd_chip ), .GND_1(
gnd_chip ), .CLK_FB_N( CLK_FB_N ), .VCTROL( VCTROL ), .XTALP( XTALP ),
.VCOB( net023 ) );

inductor #(.r(100m), .l(4n)) (*
integer library_binding
 = "analogLib";
 *)
L14 ( gnd_vco, cds_globals.\gnd!  );
inductor #(.r(100m), .l(4n)) (*
integer library_binding
 = "analogLib";
 *)
L15 ( vdd_vco, net034 );
inductor #(.r(100m), .l(4n)) (*
integer library_binding
 = "analogLib";
 *)
L3 ( gnd_chip, cds_globals.\gnd!  );
inductor #(.r(100m), .l(4n)) (*
integer library_binding
 = "analogLib";
 *)
L8 ( vdd_chip, net012 );
inductor #(.r(100m), .l(4n)) (*
integer library_binding
 = "analogLib";
 *)
L16 ( vdd_vco, net034 );
inductor #(.r(100m), .l(4n)) (*
integer library_binding
 = "analogLib";
 *)
L12 ( I_SINK_10u, net028 );
inductor #(.r(100m), .l(4n)) (*
integer library_binding
 = "analogLib";
 *)
L17 ( gnd_vco, cds_globals.\gnd!  );
inductor #(.r(100m), .l(4n)) (*
integer library_binding
 = "analogLib";
 *)
L9 ( vdd_chip, net012 );
inductor #(.r(100m), .l(4n)) (*
integer library_binding
 = "analogLib";
 *)
L0 ( gnd_chip, cds_globals.\gnd!  );

vsource #(.type("dc"), .dc(1.8)) (*
integer library_binding
 = "analogLib";
 *)
V4 ( net034, cds_globals.\gnd!  );
vsource #(.type("dc"), .dc(1.8)) (*
integer library_binding
 = "analogLib";
 *)
L1 ( net012, cds_globals.\gnd!  );

isource #(.type("dc"), .dc(10u)) (*
integer library_binding
 = "analogLib";
 *)
V0 ( cds_globals.\gnd! , net028 );

vsource #(.val0(1.8), .val1(0), .delay(cds_globals.tdelay), .type("pulse"),
 .fall(1n), .width(31.25n), .rise(1n), .period(62.5n)) (*
integer
library_binding = "analogLib";
 *)
V8 ( CLK_FB, gnd_chip );
vsource #(.val0(0), .val1(1.8), .delay(cds_globals.tdelay), .type("pulse"),
 .fall(1n), .width(31.25n), .rise(1n), .period(62.5n)) (*
integer
library_binding = "analogLib";
 *)
V7 ( CLK_FB_N, gnd_chip );
vsource #(.val0(0), .val1(1.8), .type("pulse"), .fall(1n), .width(31.25n),
 .rise(1n), .period(62.5n)) (*
integer library_binding = "analogLib";

 *)
V6 ( XTALN, cds_globals.\gnd!  );
vsource #(.val0(1.8), .val1(0), .type("pulse"), .fall(1n), .width(31.25n),
 .rise(1n), .period(62.5n)) (*
integer library_binding = "analogLib";

 *)
V3 ( XTALP, cds_globals.\gnd!  );

capacitor #(.c(50p)) (*
integer library_binding = "analogLib";
 *)
C10
 ( I_SINK_10u, gnd_chip );
capacitor #(.c(50p)) (*
integer library_binding = "analogLib";
 *)
C0
 ( vdd_chip, gnd_chip );
capacitor #(.c(1p)) (*
integer library_binding = "analogLib";
 *)
C9
 ( net028, cds_globals.\gnd!  );
capacitor #(.c(50p)) (*
integer library_binding = "analogLib";
 *)
C14
 ( vdd_vco, gnd_vco );

endmodule
