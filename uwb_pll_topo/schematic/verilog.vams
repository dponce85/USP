// Verilog-AMS netlist generated by the AMS netlister, version  IC6.1.6-64b.500.11 .
// Cadence Design Systems, Inc.

`include "disciplines.vams"

(* cds_ams_schematic *)
module uwb_pll_topo ( XTALN,TRIMP,I_SRC_10U,
CLK_FB,GND_VCO,VDD_VCO,VDD_1,GND_1,CLK_FB_N,VCTROL,XTALP,VCOB );

inout   XTALN;
inout   TRIMP;
inout   I_SRC_10U;
inout   CLK_FB;

inout   GND_VCO;
inout   VDD_VCO;
inout   VDD_1;
inout   GND_1;

inout   CLK_FB_N;
inout   VCTROL;
inout   XTALP;
inout   VCOB;

wire [0:7] VON;
wire [0:7] VOP;

PAD50LAR_TRL (*
integer library_binding = "tpb018v";
 *)
I25 ( .noConn(
VCOB ) );
PAD50LAR_TRL (*
integer library_binding = "tpb018v";
 *)
I21 ( .noConn(
TRIMP ) );
PAD50LAR_TRL (*
integer library_binding = "tpb018v";
 *)
I20 ( .noConn(
I_SRC_10U ) );
PAD50LAR_TRL (*
integer library_binding = "tpb018v";
 *)
I19 ( .noConn(
VDD_1 ) );
PAD50LAR_TRL (*
integer library_binding = "tpb018v";
 *)
I14 ( .noConn(
XTALN ) );
PAD50LAR_TRL (*
integer library_binding = "tpb018v";
 *)
I18 ( .noConn(
VDD_VCO ) );
PAD50LAR_TRL (*
integer library_binding = "tpb018v";
 *)
I16 ( .noConn(
GND_VCO ) );
PAD50LAR_TRL (*
integer library_binding = "tpb018v";
 *)
I17 ( .noConn(
GND_1 ) );
PAD50LAR_TRL (*
integer library_binding = "tpb018v";
 *)
I13 ( .noConn(
XTALP ) );

ndio #(.m(1), .pj(4E-05), .area(1E-10)) (*
integer library_binding
 = "tsmc18";
integer passed_mfactor = "m";
 *)
D0 ( GND_1, XTALP );
ndio #(.m(1), .pj(4E-05), .area(1E-10)) (*
integer library_binding
 = "tsmc18";
integer passed_mfactor = "m";
 *)
D1 ( GND_1, XTALN );

uwb_fdiv64 (*
integer library_binding = "uwb_system";
 *)
I72 ( .GND(
GND_1 ), .VDD( VDD_1 ), .RESET( net022 ), .CKN( VOP[4] ), .VON(
CLK_FB_N ), .VOP( CLK_FB ), .CKP( VON[4] ) );

uwb_osc_ring_diff7 (*
integer library_binding = "uwb_system";
 *)
I65
 ( .GND( GND_VCO ), .VDD( VDD_VCO ), .TRIMP( TRIMP ), .VON( VON[0:7] ),
.VOP( VOP[0:7] ), .VCONTROL( VCTROL ) );

uwb_loop_filter (*
integer library_binding = "uwb_system";
 *)
I40 ( .GND(
GND_1 ), .VCTROL( VCTROL ) );

uwb_cpF (*
integer library_binding = "uwb_system";
 *)
I139 ( .GND(
GND_1 ), .VDD( VDD_1 ), .PUP( XUP ), .PDN( DN ), .ISNK10U( I_SRC_10U ),
.PCOMP( VCTROL ) );

uwb_pfd (*
integer library_binding = "uwb_system";
 *)
I134 ( .GND(
GND_1 ), .VDD( VDD_1 ), .DNN( XUP ), .CKN( CLK_FB_N ), .REFN( XTALN ),
.UPN( net94 ), .DNP( net93 ), .CKP( CLK_FB ), .REFP( XTALP ), .UPP( DN ) );

endmodule
