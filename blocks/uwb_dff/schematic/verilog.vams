// Verilog-AMS netlist generated by the AMS netlister, version  IC6.1.6-64b.500.11 .
// Cadence Design Systems, Inc.

`include "disciplines.vams"

(* cds_ams_schematic *)
module uwb_dff ( CKP,CKN,D,RESET,Q,QN,VDD,GND );

inout   CKP;
inout   CKN;
inout   D;
inout   RESET;
inout   Q;

inout   QN;
inout   VDD;
inout   GND;

parameter v0=0;
parameter v1=1.8;
parameter td=5E-11;
parameter dir=1;
parameter init_state=0;
parameter tt=5E-11;

nch #(.ad(2.064E-13), .nrd(1.03333), .w(300n), .sca(0), .pd(1.88u), .scc(0),
 .scb(0), .as(2.064E-13), .nrs(1.03333), .m(1), .ps(1.88u), .sa(520.0n),
 .nf(1), .sb(520.0n), .sd(620.0n), .l(180.0n)) (*
integer
library_binding = "tsmc18";
integer passed_mfactor = "m";
 *)
M0 ( MEM,
RESET, GND, GND );

uwb_inversor (*
integer library_binding = "uwb_system";
 *)
I18 ( .in(
CKP ), .out( CKNI ), .gnd( GND ), .vdd( VDD ) );
uwb_inversor (*
integer library_binding = "uwb_system";
 *)
I6 ( .in(
net30 ), .out( Q ), .gnd( GND ), .vdd( VDD ) );
uwb_inversor (*
integer library_binding = "uwb_system";
 *)
I4 ( .in(
MEM ), .out( net21 ), .gnd( GND ), .vdd( VDD ) );
uwb_inversor (*
integer library_binding = "uwb_system";
 *)
I9 ( .in(
CKN ), .out( CKPI ), .gnd( GND ), .vdd( VDD ) );
uwb_inversor (*
integer library_binding = "uwb_system";
 *)
I7 ( .in(
Q ), .out( QN ), .gnd( GND ), .vdd( VDD ) );
uwb_inversor (*
integer library_binding = "uwb_system";
 *)
I5 ( .in(
net21 ), .out( net32 ), .gnd( GND ), .vdd( VDD ) );

uwb_passgate (*
integer library_binding = "uwb_system";
 *)
I2 ( .GND(
GND ), .VDD( VDD ), .IN( net21 ), .OUT( net30 ), .CLK( CKPI ), .CLK_N(
CKNI ) );
uwb_passgate (*
integer library_binding = "uwb_system";
 *)
I0 ( .GND(
GND ), .VDD( VDD ), .IN( D ), .OUT( MEM ), .CLK( CKNI ), .CLK_N( CKPI ) );
uwb_passgate (*
integer library_binding = "uwb_system";
 *)
I3 ( .GND(
GND ), .VDD( VDD ), .IN( net30 ), .OUT( QN ), .CLK( CKNI ), .CLK_N(
CKPI ) );
uwb_passgate (*
integer library_binding = "uwb_system";
 *)
I1 ( .GND(
GND ), .VDD( VDD ), .IN( net32 ), .OUT( MEM ), .CLK( CKPI ), .CLK_N(
CKNI ) );

endmodule
