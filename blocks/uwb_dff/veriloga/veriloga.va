// VerilogA for uwb_system, uwb_dff, veriloga

`include "constants.vams"
`include "disciplines.vams"

module uwb_dff(CKP, CKN, D, RESET, Q, QN, VDD, GND);

electrical CKP, CKN, D, RESET, Q, QN, VDD, GND;

parameter real v0=0;
parameter real v1=1.8 from (v0:inf);
parameter integer dir=1 from [-1:1] exclude 0;
parameter real td = 50p from [0:inf);
parameter real tt = 50p from [0:inf);
parameter integer init_state=0 from [0:1];

integer actNow, out, state;
real thresh;

analog begin
    thresh = (v0+v1)/2;
    actNow = 0;

    @(cross(V(CKP) - thresh, dir) or cross(V(RESET) - thresh, +1)) begin
	actNow = 1;
	state = (V(D) > thresh) && (V(RESET) < thresh);
    end

    @(initial_step) begin
	actNow = 1;
	state = init_state;
    end

    out = idt(0, state, actNow);
    V(Q) <+ transition(out ? v1 : v0, td, tt);
    V(QN) <+ v0 + v1 - V(Q);
end
endmodule
