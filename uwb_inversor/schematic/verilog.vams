// Verilog-AMS netlist generated by the AMS netlister, version  IC6.1.6-64b.500.11 .
// Cadence Design Systems, Inc.

`include "disciplines.vams"

(* cds_ams_schematic *)
module uwb_inversor ( GND,VDD,IN,OUT );

inout   GND;
inout   VDD;
inout   IN;
inout   OUT;

nch #(.ad(2.049E-13), .nrd(1.08772), .w(285.00n), .sca(0), .pd(1.88u),
 .scc(0), .scb(0), .as(2.049E-13), .nrs(1.08772), .m(1), .ps(1.88u), .sa(520.0n),
 .nf(1), .sb(520.0n), .sd(620.0n), .l(180.0n)) (*
integer
library_binding = "tsmc18";
integer passed_mfactor = "m";
 *)
M0 ( OUT,
IN, GND, GND );

pch #(.ad(4.8E-13), .nrd(0.27), .w(1u), .sca(0), .pd(2.96u), .scc(0),
.scb(0), .as(4.8E-13), .nrs(0.27), .m(1), .ps(2.96u), .sa(480.0n), .nf(1),
 .sb(480.0n), .sd(540.0n), .l(180.0n)) (*
integer library_binding
 = "tsmc18";
integer passed_mfactor = "m";
 *)
M1 ( OUT, IN, VDD, VDD );

endmodule
